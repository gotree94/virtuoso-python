.SUBCKT INV A Y VDD VSS
MN0 Y A VSS VSS g45n1svt w=0.12u l=0.045u nf=1 m=1
MP0 Y A VDD VDD g45p1svt w=0.24u l=0.045u nf=1 m=1
.ENDS
