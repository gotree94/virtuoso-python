.SUBCKT MUX4 A0 A1 A2 A3 S0 S1 Y VDD VSS
X0 A0 A1 S0 Y0 VDD VSS MUX2
X1 A2 A3 S0 Y1 VDD VSS MUX2
X2 Y0 Y1 S1 Y VDD VSS MUX2
.ENDS
