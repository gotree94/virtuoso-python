.SUBCKT NOR8 A0 A1 A2 A3 A4 A5 A6 A7 Y VDD VSS
MN0 Y A0 VSS VSS g45n1svt w=0.12u l=0.045u nf=1 m=1
MN1 Y A1 VSS VSS g45n1svt w=0.12u l=0.045u nf=1 m=1
MN2 Y A2 VSS VSS g45n1svt w=0.12u l=0.045u nf=1 m=1
MN3 Y A3 VSS VSS g45n1svt w=0.12u l=0.045u nf=1 m=1
MN4 Y A4 VSS VSS g45n1svt w=0.12u l=0.045u nf=1 m=1
MN5 Y A5 VSS VSS g45n1svt w=0.12u l=0.045u nf=1 m=1
MN6 Y A6 VSS VSS g45n1svt w=0.12u l=0.045u nf=1 m=1
MN7 Y A7 VSS VSS g45n1svt w=0.12u l=0.045u nf=1 m=1
MP0 P1 A0 VDD VDD g45p1svt w=1.92u l=0.045u nf=1 m=1
MP1 P2 A1 P1 VDD g45p1svt w=1.92u l=0.045u nf=1 m=1
MP2 P3 A2 P2 VDD g45p1svt w=1.92u l=0.045u nf=1 m=1
MP3 P4 A3 P3 VDD g45p1svt w=1.92u l=0.045u nf=1 m=1
MP4 P5 A4 P4 VDD g45p1svt w=1.92u l=0.045u nf=1 m=1
MP5 P6 A5 P5 VDD g45p1svt w=1.92u l=0.045u nf=1 m=1
MP6 P7 A6 P6 VDD g45p1svt w=1.92u l=0.045u nf=1 m=1
MP7 Y A7 P7 VDD g45p1svt w=1.92u l=0.045u nf=1 m=1
.ENDS
